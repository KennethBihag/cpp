** fullwave-rect **
*
* NI Multisim to SPICE Netlist Export
* Generated by: Kenneth
* Tue, May 05, 2026 21:15:24
*

*## Multisim Component T1 ##*
xT1 1 0 2 3 0 Tran_T1
.subckt Tran_T1 p1pos p1neg s1pos s1neg s1tap

* Core 1P2S model
x1 p1pos p1neg s1pos s1tap s1tap s1neg 1P2S_CORE
.subckt 1P2S_CORE p1pos p1neg s1pos s1neg s2pos s2neg
***Primary coil 1
G1 p1pos p1neg value={-1/100*(10*I(Es1)+10*I(Es2))}

***Secondary coil 1
Es1 s1pos s1neg value={V(p1pos,p1neg)*10/100}

***Secondary coil 2
Es2 s2pos s2neg value={V(p1pos,p1neg)*10/100}

.ends
.ends

*## Multisim Component D2 ##*
dD2 3 4 1BH62__DIODE__1

*## Multisim Component D1 ##*
dD1 2 4 1BH62__DIODE__1

*## Multisim Component R1 ##*
rR1 4 0 300 vresR1
.model vresR1 r(  )

*## Multisim Component C1 ##*
cC1 4 0 0.0001

*## Multisim Component V1 ##*
vV1 1 0 dc 0 ac 1 0
+      distof1 0 0
+      distof2 0 0
+      sin(0 170 60 0 0 0)

.MODEL      1BH62__DIODE__1 D
+ IS=5.950e-006 N=4.031e+000 RS=2.677e-002
+ BV=1.200e+002
+ EG=1.110e+000 XTI=3.000e+000 TT=5.760e-007
+ FC=5.000e-001 KF=0.000e+000 AF=1.000e+000
